* Filtro pasabajos Butterworth N=3 - Monte Carlo de tolerancias (Nivel II)
* Abrir en LTspice (File > Open > este .cir) y correr (Run).
* Cada corrida .step sortea de nuevo TODOS los valores (uniforme, independiente).
*
* ==PARAMS==
.param tolR=0.01 tolC=0.02
* Caso b: .param tolR=0.05 tolC=0.05
* Caso c: .param tolR=0.01 tolC=0.05
* Caso d: .param tolR=0.01 tolC=0.02
.param R3v=mc(11k,tolR) R1v=mc(12k,tolR) R2v=mc(12k,tolR)
.param C3v=mc(10n,tolC) C1v=mc(4.7n,tolC) C2v=mc(18n,tolC)
* ==FIN-PARAMS==
.step param run 1 500 1

Vin vin 0 AC 1
Vp vp 0 15
Vn vn 0 -15

* Seccion 1: R3-C3 + seguidor
R3 vin n1 {R3v}
C3 n1 0 {C3v}
XU1 n1 vo1 vp vn vo1 TL082

* Seccion 2: Sallen-Key K=1
R1 vo1 na {R1v}
R2 na nb {R2v}
C1 nb 0 {C1v}
C2 na vout {C2v}
XU2 nb vout vp vn vout TL082

.ac dec 200 10 100k

* Medidas (una por corrida)
.meas ac m1k  FIND mag(V(vout)) AT 1k
.meas ac m4k  FIND mag(V(vout)) AT 4k
.meas ac f3db WHEN mag(V(vout))=0.70711 FALL=1
* Valores sorteados de cada componente (para regresion / sensibilidad)
.meas v_r3 PARAM R3v
.meas v_r1 PARAM R1v
.meas v_r2 PARAM R2v
.meas v_c3 PARAM C3v
.meas v_c1 PARAM C1v
.meas v_c2 PARAM C2v

* TL082 macromodel (copiado de FiltroPasaBajo.asc)
.SUBCKT TL082    1 2 3 4 5
  C1   11 12 3.498E-12
  C2    6  7 15.00E-12
  DC    5 53 DX
  DE   54  5 DX
  DLP  90 91 DX
  DLN  92 90 DX
  DP    4  3 DX
  EGND 99  0 POLY(2) (3,0) (4,0) 0 .5 .5
  FB    7 99 POLY(5) VB VC VE VLP VLN 0 4.715E6 -5E6 5E6 5E6 -5E6
  GA    6  0 11 12 282.8E-6
  GCM   0  6 10 99 8.942E-9
  ISS   3 10 DC 195.0E-6
  HLIM 90  0 VLIM 1K
  J1   11  2 10 JX
  J2   12  1 10 JX
  R2    6  9 100.0E3
  RD1   4 11 3.536E3
  RD2   4 12 3.536E3
  RO1   8  5 150
  RO2   7 99 150
  RP    3  4 2.143E3
  RSS  10 99 1.026E6
  VB    9  0 DC 0
  VC    3 53 DC 2.200
  VE   54  4 DC 2.200
  VLIM  7  8 DC 0
  VLP  91  0 DC 25
  VLN   0 92 DC 25
.MODEL DX D(IS=800.0E-18)
.MODEL JX PJF(IS=15.00E-12 BETA=270.1E-6 VTO=-1)
.ENDS
.end
